.title KiCad schematic
R1 /FSR1_ADC GND 10k
R2 /FSR2_ADC GND 10k
RV5 +3V3 /FSR5_ADC FSR5
RV4 +3V3 /FSR4_ADC FSR4
RV1 +3V3 /FSR1_ADC FSR1
RV2 +3V3 /FSR2_ADC FSR2
R3 /FSR3_ADC GND 10k
RV3 +3V3 /FSR3_ADC FSR3
RV6 +3V3 /FSR6_ADC FSR6
R6 /FSR6_ADC GND 10k
R4 /FSR4_ADC GND 10k
R5 /FSR5_ADC GND 10k
U2 __U2
U3 __U3
LS1 /SPK_P /SPK_N 4
U1 __U1
C1 +5V GND 1000u
C2 +5V GND 100u
R13 /DF_UART_TX /DF_RX 1k
C3 +5V GND 100n
D5 __D5
D6 __D6
R12 +5V /LED6_A 110
R11 +5V /LED5_A 110
R10 +5V /LED4_A 110
D4 __D4
R7 +5V /LED1_A 110
R8 +5V /LED2_A 110
D2 __D2
D1 __D1
R9 +5V /LED3_A 110
D3 __D3
.end
